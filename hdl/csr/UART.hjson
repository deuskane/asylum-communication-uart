{
    name      : "UART",
    width     : 8,
    desc      : "CSR for UART"
    interface : "sbi"

    parameters : [
    	{
	    name         : "USER_DEFINE_BAUD_TICK"
	    desc         : "Parameters to use the enable the User define Baud Tick"
	    type         : "boolean"
	}
    	{
	    name         : "BAUD_TICK_CNT_MAX"
	    desc         : "Default value for Baud Tick Timer"
	    type         : "std_logic_vector(15 downto 0)"
	}
	{
	    name         : "DEPTH_TX"
	    desc         : "Depth of FIFO TX (SW2HW)"
	    type         : "natural"
	}
	{
	    name         : "DEPTH_RX"
	    desc         : "Depth of FIFO RX (HW2SW)"
	    type         : "natural"
	}
    ]

    registers : [

        {
            name         : "isr",
            address      : "x0",
            desc         : "Interruption Status Register",
            swaccess     : "rw1c",
            hwaccess     : "rw",
            hwtype       : "reg",

            fields: [
                {
                    name: "value",
                    bits: "3:0",
                    desc: "0: interrupt is inactive, 1: interrupt is active. Sources (see status) : [0] TX FIFO empty, [1] TX FIFO full, [2] RX FIFO not empty, [3] RX FIFO full"
                },
            ]
        },

        {
            name         : "imr",
            address      : "x1",
            desc         : "Interruption Mask Register",
            swaccess     : "rw",
            hwaccess     : "ro",
            hwtype       : "reg",

            fields: [
                {
                    name: "enable",
                    bits: "3:0",
		    init: "x0",
                    desc: "0: interrupt is disable, 1: interrupt is enable"
                },
            ]
        },

	{
            name         : "data",
            address      : "x2",
            desc         : "Write : data to tansmit, Read : data to receive",
            swaccess     : "rw",
            hwaccess     : "rw",
            hwtype       : "fifo",

            params: {
                BLOCKING_READ  : "True", 
                BLOCKING_WRITE : "True",
		DEPTH_SW2HW    : "DEPTH_TX"
		DEPTH_HW2SW    : "DEPTH_RX"
            }

            fields: [
                {
                    name: "value",
                    bits: "7:0",
                    desc: "Data TX or Data RX"
                },
            ]
        },

        {
            name         : "status",
            address      : "x3",
            desc         : "Status Register, same bit mapping as isr and imr. Sticky bits are cleared by writing 1, writes have no effect on the other bits",
            swaccess     : "rw1c",
            hwaccess     : "rw",
            hwtype       : "ext",

            fields: [
                {
                    name: "tx_empty",
                    bits: "0",
                    desc: "Read only. 1 : TX FIFO is empty (DEPTH_TX = 0 : the transmitter can accept a byte, a write to data does not block)"
                },
                {
                    name: "tx_full",
                    bits: "1",
                    desc: "Read only. 1 : TX FIFO is full, a write to data is blocked until a byte is sent"
                },
                {
                    name: "rx_not_empty",
                    bits: "2",
                    desc: "Read only. 1 : RX FIFO is not empty, a read of data returns a byte without blocking"
                },
                {
                    name: "rx_full",
                    bits: "3",
                    desc: "Read only. 1 : RX FIFO is full"
                },
            ]
        },

        {
            name         : "ctrl_tx",
            address      : "x4",
            desc         : "Control Register",
            swaccess     : "rw",
            hwaccess     : "ro",

            fields: [
                {
                    name: "tx_enable",
                    bits: "0",
                    desc: "0 : TX is disable, 1 : TX is enable"
                },
                {
                    name: "tx_parity_enable",
                    bits: "1",
                    desc: "0 : Parity is disable, 1 : Parity is enable"
                },
                {
                    name: "tx_parity_odd",
                    bits: "2",
                    desc: "0 : Parity is even, 1 : Parity is odd"
                },
                {
                    name: "tx_use_loopback",
                    bits: "3",
                    desc: "0 : UART TX FIFO is connected to CSR, 1 : UART RX FIFO is connected to UART RX FIFO"
                },
                {
                    name: "cts_enable",
                    bits: "4",
                    desc: "0 : Clear To Send Disable, 1 : Clear To Send Enable"
                },
            ]
        },

        {
            name         : "ctrl_rx",
            address      : "x5",
            desc         : "Control Register",
            swaccess     : "rw",
            hwaccess     : "ro",

            fields: [
                {
                    name: "rx_enable",
                    bits: "0",
                    desc: "0 : RX is disable, 1 : RX is enable"
                },
                {
                    name: "rx_parity_enable",
                    bits: "1",
                    desc: "0 : Parity is disable, 1 : Parity is enable"
                },
                {
                    name: "rx_parity_odd",
                    bits: "2",
                    desc: "0 : Parity is even, 1 : Parity is odd"
                },
                {
                    name: "rx_use_loopback",
                    bits: "3",
                    desc: "0 : UART RX is connected to UART RX Input, 1 : UART RX is connected to UART TX"
                },
                {
                    name: "rts_enable",
                    bits: "4",
                    desc: "0 : Request To Send Disable, 1 : Request To Send Enable"
                },
            ]
        },


        {
            name         : "baud_tick_cnt_max_lsb",
            address      : "x6",
            desc         : "Baud Tick Counter Max LSB. Must be equal to (Clock Frequency (Hz) / Baud Rate)-1",
            swaccess     : "rw",
            hwaccess     : "ro",
            hwtype       : "reg",
	    enable       : "USER_DEFINE_BAUD_TICK",	    

	    fields: [
                {
                    name: "value",
                    bits: "7:0",
                    desc: "Baud Tick Counter Max LSB"
		    expr: "BAUD_TICK_CNT_MAX(7 downto 0)"
                },
            ]
        },

	{
            name         : "baud_tick_cnt_max_msb",
            address      : "x7",
            desc         : "Baud Tick Counter Max MSB. Must be equal to (Clock Frequency (Hz) / Baud Rate)-1",
            swaccess     : "rw",
            hwaccess     : "ro",
            hwtype       : "reg",
	    enable       : "USER_DEFINE_BAUD_TICK",

            fields: [
                {
                    name: "value",
                    bits: "7:0",
                    desc: "Baud Tick Counter Max MSB"
		    expr: "BAUD_TICK_CNT_MAX(15 downto 8)"
                },
            ]
        },
]
}
