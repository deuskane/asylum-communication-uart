{
    name      : "UART",
    width     : 8,
    desc      : "CSR for UART"
    interface : "pbi"
    registers : [
        {
            name         : "data",
            address      : "x0",
            desc         : "Write : data to tansmit, Read : data to receive",
            swaccess     : "rw",
            hwaccess     : "rw",
            hwtype       : "fifo",

            params: {
                BLOCKING_READ  : "True", 
                BLOCKING_WRITE : "True",
            }

            fields: [
                {
                    name: "value",
                    bits: "7:0",
                    desc: "Data TX or Data RX"
                },
            ]
        },

        {
            name         : "ctrl",
            address      : "x1",
            desc         : "Control Register",
            swaccess     : "rw",
            hwaccess     : "ro",

            fields: [
                {
                    name: "enable_tx",
                    bits: "0",
                    desc: "0 : TX is disable, 1 : TX is enable"
                },
                {
                    name: "enable_rx",
                    bits: "1",
                    desc: "0 : RX is disable, 1 : RX is enable"
                },
                {
                    name: "parity_enable",
                    bits: "2",
                    desc: "0 : Parity is disable, 1 : Parity is enable"
                },
                {
                    name: "parity_odd",
                    bits: "3",
                    desc: "0 : Parity is even, 1 : Parity is odd"
                },
                {
                    name: "loopback",
                    bits: "7",
                    desc: "0 : UART RX is connected to input, 1 : UART RX is connected to UART TX"
                },
            ]
        },

]
}
