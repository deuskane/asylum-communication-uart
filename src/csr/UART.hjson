{
    name      : "UART",
    width     : 8,
    desc      : "CSR for UART"
    interface : "pbi"

    parameters : [
    	{
	    name         : "USER_DEFINE_BAUD_TICK"
	    desc         : "Parameters to use the enable the User define Baud Tick"
	    type         : "boolean"
	}
    	{
	    name         : "BAUD_TICK_CNT_MAX"
	    desc         : "Default value for Baud Tick Timer"
	    type         : "std_logic_vector(15 downto 0)"
	}
	{
	    name         : "DEPTH_TX"
	    desc         : "Depth of FIFO TX (SW2HW)"
	    type         : "natural"
	}
	{
	    name         : "DEPTH_RX"
	    desc         : "Depth of FIFO RX (HW2SW)"
	    type         : "natural"
	}
    ]

    registers : [
        {
            name         : "data",
            address      : "x0",
            desc         : "Write : data to tansmit, Read : data to receive",
            swaccess     : "rw",
            hwaccess     : "rw",
            hwtype       : "fifo",

            params: {
                BLOCKING_READ  : "True", 
                BLOCKING_WRITE : "True",
		DEPTH_SW2HW    : "DEPTH_TX"
		DEPTH_HW2SW    : "DEPTH_RX"
            }

            fields: [
                {
                    name: "value",
                    bits: "7:0",
                    desc: "Data TX or Data RX"
                },
            ]
        },

        {
            name         : "ctrl",
            address      : "x1",
            desc         : "Control Register",
            swaccess     : "rw",
            hwaccess     : "ro",

            fields: [
                {
                    name: "tx_enable",
                    bits: "0",
                    desc: "0 : TX is disable, 1 : TX is enable"
                },
                {
                    name: "tx_parity_enable",
                    bits: "1",
                    desc: "0 : Parity is disable, 1 : Parity is enable"
                },
                {
                    name: "tx_parity_odd",
                    bits: "2",
                    desc: "0 : Parity is even, 1 : Parity is odd"
                },
                {
                    name: "tx_use_loopback",
                    bits: "3",
                    desc: "0 : UART TX FIFO is connected to CSR, 1 : UART RX FIFO is connected to UART RX FIFO"
                },
                {
                    name: "rx_enable",
                    bits: "4",
                    desc: "0 : RX is disable, 1 : RX is enable"
                },
                {
                    name: "rx_parity_enable",
                    bits: "5",
                    desc: "0 : Parity is disable, 1 : Parity is enable"
                },
                {
                    name: "rx_parity_odd",
                    bits: "6",
                    desc: "0 : Parity is even, 1 : Parity is odd"
                },
                {
                    name: "rx_use_loopback",
                    bits: "7",
                    desc: "0 : UART RX is connected to UART RX Input, 1 : UART RX is connected to UART TX"
                },
            ]
        },

        {
            name         : "baud_tick_cnt_max_lsb",
            address      : "x2",
            desc         : "Baud Tick Counter Max LSB. Must be equal to (Clock Frequency (Hz) / Baud Rate)-1",
            swaccess     : "rw",
            hwaccess     : "ro",
            hwtype       : "reg",
	    enable       : "USER_DEFINE_BAUD_TICK",	    

	    fields: [
                {
                    name: "value",
                    bits: "7:0",
                    desc: "Baud Tick Counter Max LSB"
		    expr: "BAUD_TICK_CNT_MAX(7 downto 0)"
                },
            ]
        },

	{
            name         : "baud_tick_cnt_max_msb",
            address      : "x3",
            desc         : "Baud Tick Counter Max MSB. Must be equal to (Clock Frequency (Hz) / Baud Rate)-1",
            swaccess     : "rw",
            hwaccess     : "ro",
            hwtype       : "reg",
	    enable       : "USER_DEFINE_BAUD_TICK",

            fields: [
                {
                    name: "value",
                    bits: "7:0",
                    desc: "Baud Tick Counter Max MSB"
		    expr: "BAUD_TICK_CNT_MAX(15 downto 8)"
                },
            ]
        },
]
}
